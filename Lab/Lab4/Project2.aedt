# Ansys Electronics Desktop project, version 2018.0
materials:
  vacuum: permittivity=1
  air: permittivity=1.0006 permeability=1.0000004

design HFSSDesign1 (HFSS, DrivenModal, model units mm)
geometry:
  Box1 [air] = box(corner=(0mm, 0mm, 0mm), size=(22.86mm, 10.16mm, 50mm))
boundaries and excitations:
  PerfE1: Perfect E Objects=Box1 Faces=Box1.face(all 6)
  1: Wave Port Faces=Box1.face(-z) NumModes=4 Modes{Mode1{CharImp=Zpi} Mode2{CharImp=Zpi} Mode3{CharImp=Zpi} Mode4{CharImp=Zpi}}
  2: Wave Port Faces=Box1.face(+z) NumModes=4 Modes{Mode1{CharImp=Zpi} Mode2{CharImp=Zpi} Mode3{CharImp=Zpi} Mode4{CharImp=Zpi}}
setups:
  Setup1: HfssDriven Frequency=13GHz MaxDeltaS=0.02 MaximumPasses=6 MinimumPasses=1 MinimumConvergedPasses=1 PercentRefinement=30 BasisOrder=1 PortAccuracy=2
    sweep Sweep: 1GHz to 20GHz, 451 points; Type=Interpolating InterpTolerance=0.5 InterpMaxSolns=250 InterpUsePortImped=false PassivityErrorTolerance=0.0001
source amplitudes:
  1:1: 1W 0deg
  1:2, 1:3, 1:4, 2:1..2:4: 0W 0deg
field plots:
  Vector_E1: E Field over Box1.face(-z) on Setup1 : LastAdaptive at Freq=13GHz Phase=0deg
  Vector_E2, Mag_E1: E Field over Box1.face(+y) on Setup1 : LastAdaptive at Freq=13GHz Phase=0deg
  Vector_H1: H Field over Box1.face(+y) on Setup1 : LastAdaptive at Freq=13GHz Phase=0deg
  Vector_H2: H Field over Box1.face(-x, +x) on Setup1 : LastAdaptive at Freq=13GHz Phase=0deg
  Vector_H3: H Field over Box1.face(-z) on Setup1 : LastAdaptive at Freq=13GHz Phase=0deg
reports:
  S Parameter Plot 1: dB(S(2:1,1:1)) vs Freq on Setup1 : Sweep
  Gamma Plot 1: im(Gamma(1:1)) vs Freq on Setup1 : Sweep
